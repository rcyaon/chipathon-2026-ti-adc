* Ideal Double-Tail / StrongARM Comparator Subcircuit (7 Pins)
* Precharge High (CLK Low -> OUTP=VDD, OUTN=VDD)
* Pins: INP INN CLK VDD VSS OUTP OUTN
.subckt IDcomparator INP INN CLK VDD VSS OUTP OUTN
+ PARAMS: VTH=1.65 VOS=0 VNOISE=0 GMIN=2m GMEFF=10m

* Step 1: Smooth Clock Gate Factor (0 during reset, 1 during active evaluation)
B_gate GATE 0 V = 0.5 * (1 + tanh((V(CLK) - {VTH}) * 50))

* Step 2: Differential Input Evaluation (Includes Offset & Thermal Noise)
B_in IN_DIFF 0 V = V(INP) - V(INN) - {VOS} + {VNOISE}

* Step 3: Bounded Regenerative Latch Core
C_latch INT 0 1pf
B_latch 0 INT I = V(GATE) * ({GMIN}*V(IN_DIFF) + {GMEFF}*tanh(V(INT)*5)) - (1 - V(GATE)) * (V(INT) / 10)

* Step 4: Rail-to-Rail Precharge-High Output Mapping
* Reset Phase (GATE = 0): OUTP = VDD, OUTN = VDD
* Evaluation Phase (GATE = 1): INP > INN -> OUTP = VDD, OUTN = 0V
*                              INP < INN -> OUTP = 0V,  OUTN = VDD
B_outp_int OUTP_int 0 V = V(VDD) * (1 - V(GATE) * 0.5 * (1 - tanh(V(INT) * 10)))
B_outn_int OUTN_int 0 V = V(VDD) * (1 - V(GATE) * 0.5 * (1 + tanh(V(INT) * 10)))

* Step 5: Output Smoothing Filters (Prevents matrix timestep crashes)
R_outp OUTP_int OUTP 50
C_outp OUTP 0 5ff

R_outn OUTN_int OUTN 50
C_outn OUTN 0 5ff

.ends IDcomparator
