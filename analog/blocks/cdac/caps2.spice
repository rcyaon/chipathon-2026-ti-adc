** sch_path: /foss/designs/chipathon-2026-ti-adc/analog/blocks/cdac/caps2.sch
.subckt caps2 Dx_b<0> Dx_b<1> Dx_b<2> Dx_b<3> Vin Dx_b<4> Dx_b<5> GND Dx_b<6> Dx_b<7> VREF Dx_b<8> ~phi_t phi_t Dx_b<9> Dx<0> VDD
+ Dx<1> Vx Dx<2> Dx<3> Vx_lsb Dx<4> Dx<5> phi_b ~phi_b Dx<6> VCM Dx<7> Dx<8> Dx<9>
*.PININFO Vin:I GND:I VREF:I Vx:O phi_t:I VDD:I Dx_b<0>:I Dx<0>:I Dx_b<1>:I Dx_b<2>:I Dx_b<3>:I Dx_b<4>:I Dx_b<5>:I Dx_b<6>:I
*+ Dx_b<7>:I Dx_b<8>:I Dx_b<9>:I Dx<1>:I Dx<2>:I Dx<3>:I Dx<4>:I Dx<5>:I Dx<6>:I Dx<7>:I Dx<8>:I Dx<9>:I Vx_lsb:O ~phi_t:I VCM:I phi_b:I
*+ ~phi_b:I
XC1 net2 Vx_lsb cap_mim_2f0fF c_width=5e-6 c_length=5e-6
XC2 net1 Vx_lsb cap_mim_2f0fF c_width=5e-6 c_length=5e-6
XC3 net3 Vx_lsb cap_mim_2f0fF c_width=5e-6 c_length=5e-6 m=2
XC4 net4 Vx_lsb cap_mim_2f0fF c_width=5e-6 c_length=5e-6 m=4
XC5 net5 Vx_lsb cap_mim_2f0fF c_width=5e-6 c_length=5e-6 m=8
XC6 net6 Vx cap_mim_2f0fF c_width=5e-6 c_length=5e-6
XC7 net7 Vx cap_mim_2f0fF c_width=5e-6 c_length=5e-6
XC8 net8 Vx cap_mim_2f0fF c_width=5e-6 c_length=5e-6 m=2
XC9 net9 Vx cap_mim_2f0fF c_width=5e-6 c_length=5e-6 m=4
XC10 net10 Vx cap_mim_2f0fF c_width=5e-6 c_length=5e-6 m=8
XC11 Vx_lsb Vx cap_mim_2f0fF c_width=5.16e-6 c_length=5.16e-6
M4 VCM ~phi_t Vx VDD pfet_03v3 L=0.28u W=2u nf=1
M1 Vx phi_t VCM GND nfet_03v3 L=0.28u W=1u nf=1
M2 VCM ~phi_t Vx_lsb VDD pfet_03v3 L=0.28u W=2u nf=1
M3 Vx_lsb phi_t VCM GND nfet_03v3 L=0.28u W=1u nf=1
x1 VDD Dx<0> Dx_b<0> VREF ~phi_b phi_b Vin net2 GND transistors3
x2 VDD Dx<2> Dx_b<2> VREF ~phi_b phi_b Vin net3 GND transistors3
x3 VDD Dx<4> Dx_b<4> VREF ~phi_b phi_b Vin net5 GND transistors3
x4 VDD Dx<5> Dx_b<5> VREF ~phi_b phi_b Vin net6 GND transistors3
x5 VDD Dx<7> Dx_b<7> VREF ~phi_b phi_b Vin net8 GND transistors3
x6 VDD Dx<9> Dx_b<9> VREF ~phi_b phi_b Vin net10 GND transistors3
x7 VDD Dx<8> Dx_b<8> VREF ~phi_b phi_b Vin net9 GND transistors3
x8 VDD Dx<6> Dx_b<6> VREF ~phi_b phi_b Vin net7 GND transistors3
x9 VDD Dx<3> Dx_b<3> VREF ~phi_b phi_b Vin net4 GND transistors3
x10 VDD Dx<1> Dx_b<1> VREF ~phi_b phi_b Vin net1 GND transistors3
.ends

* expanding   symbol:  chipathon-2026-ti-adc/analog/blocks/cdac/transistors3.sym # of pins=9
** sym_path: /foss/designs/chipathon-2026-ti-adc/analog/blocks/cdac/transistors3.sym
** sch_path: /foss/designs/chipathon-2026-ti-adc/analog/blocks/cdac/transistors3.sch
.subckt transistors3 VDD Dx Dx_b VREF phi_s phi_s_b Vin sw_node GND
*.PININFO Vin:I VREF:I sw_node:O GND:I Dx:I Dx_b:I phi_s:I VDD:I phi_s_b:I
M4 sw_node Dx_b VREF VDD pfet_03v3 L=0.28u W=1u nf=1
M6 sw_node Dx_b GND GND nfet_03v3 L=0.28u W=0.5u nf=1
M7 GND Dx sw_node VDD pfet_03v3 L=0.28u W=1u nf=1
M2 sw_node phi_s Vin VDD pfet_03v3 L=0.28u W=1u nf=1
M1 VREF Dx sw_node GND nfet_03v3 L=0.28u W=0.5u nf=1
M8 Vin phi_s_b sw_node GND nfet_03v3 L=0.28u W=0.5u nf=1
.ends
