** sch_path: /foss/designs/cdac/caps_tb.sch
** Final merged CDAC testbench.
** Assembled from: caps.spice (cell body, split MSB/LSB + bridge),
**                 caps_tb.spice (real .subckt pin order + top-level wiring),
**                 testing.spice (complete Dx/Dx_b stimulus + measurements)
**
** NOTE ON PIN ORDER: caps.spice's "**.subckt caps ..." header is a commented-out
** leftover (that file's .subckt/.ends wrappers are all commented, so it netlisted
** as a flat top-level cell). The pin order below is the REAL one, taken from the
** active (uncommented) ".subckt caps" line in caps_tb.spice / testing.spice.

.GLOBAL GND

* ============================================================
* GF180MCU device models -- adjust path if your PDK_ROOT differs
* ============================================================
.include "$PDK_ROOT/gf180mcuD/libs.tech/ngspice/design.ngspice"
.lib "$PDK_ROOT/gf180mcuD/libs.tech/ngspice/sm141064.ngspice" typical
.lib "$PDK_ROOT/gf180mcuD/libs.tech/ngspice/sm141064.ngspice" cap_mim

* ---- nominal (non-Monte Carlo) values for cap_mim's corner/mismatch scaling params ----
* cap_mim_2f0fF's formula (c_cox='1.99e-3*mim_corner_2p0fF', c_c0=...*(1+mc_c_cox_2p0fF)')
* depends on these but they're not defined by .lib cap_mim or design.ngspice;
* for a typical run: corner multiplier = 1, mismatch term = 0.
.param mim_corner_2p0fF=1
.param mc_c_cox_2p0fF=0

* ============================================================
* Top-level instantiation of the CDAC cell (positional, 27 nodes)
* Order: Dx_b<0> Dx_b<1> Dx_b<2> Dx_b<3> Vin Dx_b<4> GND Dx_b<5> Dx_b<6> Dx_b<7>
*        VREF Dx_b<8> phi_s Dx_b<9> Dx<0> VDD Dx<1> Vx Dx<2> Dx<3> Vx_lsb
*        Dx<4> Dx<5> Dx<6> Dx<7> Dx<8> Dx<9>
*
* NOTE ON Vx: "Vx" is only a pin NAME on the .subckt caps definition. At the
* top level it doesn't exist as a node -- positional connection makes it
* alias to net17 (17th pin in the list above). All measurements, wrdata,
* and plot commands below reference net17, not Vx, for that reason.
* ============================================================
x1 net5 net6 net7 net8 net1 net9 GND net10 net11 net12 net3 net13 net4 net14 net15 net2 net16 net17 net18 net19 net20 net21 net22
+ net23 net24 net25 net26 caps

* ---- static rails ----
V1 net2 GND 3.3        $ VDD
V2 net1 GND 0.9        $ Vin (DC -- DAC-only test, no analog input needed for a code-transfer sweep)
V3 net4 GND PULSE(0 3.3 0 1n 1n 30n 300n)   $ phi_s sampling clock -- period re-synced to new 300ns code cadence (was 500n, matching old code hold; duty cycle preserved ~1:10)
V4 net3 GND 1.8        $ VREF -- ### CONFIRM: earlier hand-sizing assumed VREF=1V; this TB uses 1.8V ###

**** full 256-code monotonic sweep stimulus (replaces old spot-check codes A-G) ****
* Each code held 300ns, 256 codes, total sweep = 76800ns
* Dummies Dx<0>(net15)/Dx<5>(net22) tied low permanently, as before.

VDX0  net15 GND 0
VDXB0 net5  GND 3.3

VDX5  net22 GND 0
VDXB5 net10 GND 3.3

VDX1  net16 GND PWL(0.0000n 0 300.0000n 0 300.1000n 3.3 600.0000n 3.3 600.1000n 0 900.0000n 0 900.1000n 3.3 1200.0000n 3.3
+ 1200.1000n 0 1500.0000n 0 1500.1000n 3.3 1800.0000n 3.3 1800.1000n 0 2100.0000n 0 2100.1000n 3.3 2400.0000n 3.3
+ 2400.1000n 0 2700.0000n 0 2700.1000n 3.3 3000.0000n 3.3 3000.1000n 0 3300.0000n 0 3300.1000n 3.3 3600.0000n 3.3
+ 3600.1000n 0 3900.0000n 0 3900.1000n 3.3 4200.0000n 3.3 4200.1000n 0 4500.0000n 0 4500.1000n 3.3 4800.0000n 3.3
+ 4800.1000n 0 5100.0000n 0 5100.1000n 3.3 5400.0000n 3.3 5400.1000n 0 5700.0000n 0 5700.1000n 3.3 6000.0000n 3.3
+ 6000.1000n 0 6300.0000n 0 6300.1000n 3.3 6600.0000n 3.3 6600.1000n 0 6900.0000n 0 6900.1000n 3.3 7200.0000n 3.3
+ 7200.1000n 0 7500.0000n 0 7500.1000n 3.3 7800.0000n 3.3 7800.1000n 0 8100.0000n 0 8100.1000n 3.3 8400.0000n 3.3
+ 8400.1000n 0 8700.0000n 0 8700.1000n 3.3 9000.0000n 3.3 9000.1000n 0 9300.0000n 0 9300.1000n 3.3 9600.0000n 3.3
+ 9600.1000n 0 9900.0000n 0 9900.1000n 3.3 10200.0000n 3.3 10200.1000n 0 10500.0000n 0 10500.1000n 3.3 10800.0000n 3.3
+ 10800.1000n 0 11100.0000n 0 11100.1000n 3.3 11400.0000n 3.3 11400.1000n 0 11700.0000n 0 11700.1000n 3.3 12000.0000n 3.3
+ 12000.1000n 0 12300.0000n 0 12300.1000n 3.3 12600.0000n 3.3 12600.1000n 0 12900.0000n 0 12900.1000n 3.3 13200.0000n 3.3
+ 13200.1000n 0 13500.0000n 0 13500.1000n 3.3 13800.0000n 3.3 13800.1000n 0 14100.0000n 0 14100.1000n 3.3 14400.0000n 3.3
+ 14400.1000n 0 14700.0000n 0 14700.1000n 3.3 15000.0000n 3.3 15000.1000n 0 15300.0000n 0 15300.1000n 3.3 15600.0000n 3.3
+ 15600.1000n 0 15900.0000n 0 15900.1000n 3.3 16200.0000n 3.3 16200.1000n 0 16500.0000n 0 16500.1000n 3.3 16800.0000n 3.3
+ 16800.1000n 0 17100.0000n 0 17100.1000n 3.3 17400.0000n 3.3 17400.1000n 0 17700.0000n 0 17700.1000n 3.3 18000.0000n 3.3
+ 18000.1000n 0 18300.0000n 0 18300.1000n 3.3 18600.0000n 3.3 18600.1000n 0 18900.0000n 0 18900.1000n 3.3 19200.0000n 3.3
+ 19200.1000n 0 19500.0000n 0 19500.1000n 3.3 19800.0000n 3.3 19800.1000n 0 20100.0000n 0 20100.1000n 3.3 20400.0000n 3.3
+ 20400.1000n 0 20700.0000n 0 20700.1000n 3.3 21000.0000n 3.3 21000.1000n 0 21300.0000n 0 21300.1000n 3.3 21600.0000n 3.3
+ 21600.1000n 0 21900.0000n 0 21900.1000n 3.3 22200.0000n 3.3 22200.1000n 0 22500.0000n 0 22500.1000n 3.3 22800.0000n 3.3
+ 22800.1000n 0 23100.0000n 0 23100.1000n 3.3 23400.0000n 3.3 23400.1000n 0 23700.0000n 0 23700.1000n 3.3 24000.0000n 3.3
+ 24000.1000n 0 24300.0000n 0 24300.1000n 3.3 24600.0000n 3.3 24600.1000n 0 24900.0000n 0 24900.1000n 3.3 25200.0000n 3.3
+ 25200.1000n 0 25500.0000n 0 25500.1000n 3.3 25800.0000n 3.3 25800.1000n 0 26100.0000n 0 26100.1000n 3.3 26400.0000n 3.3
+ 26400.1000n 0 26700.0000n 0 26700.1000n 3.3 27000.0000n 3.3 27000.1000n 0 27300.0000n 0 27300.1000n 3.3 27600.0000n 3.3
+ 27600.1000n 0 27900.0000n 0 27900.1000n 3.3 28200.0000n 3.3 28200.1000n 0 28500.0000n 0 28500.1000n 3.3 28800.0000n 3.3
+ 28800.1000n 0 29100.0000n 0 29100.1000n 3.3 29400.0000n 3.3 29400.1000n 0 29700.0000n 0 29700.1000n 3.3 30000.0000n 3.3
+ 30000.1000n 0 30300.0000n 0 30300.1000n 3.3 30600.0000n 3.3 30600.1000n 0 30900.0000n 0 30900.1000n 3.3 31200.0000n 3.3
+ 31200.1000n 0 31500.0000n 0 31500.1000n 3.3 31800.0000n 3.3 31800.1000n 0 32100.0000n 0 32100.1000n 3.3 32400.0000n 3.3
+ 32400.1000n 0 32700.0000n 0 32700.1000n 3.3 33000.0000n 3.3 33000.1000n 0 33300.0000n 0 33300.1000n 3.3 33600.0000n 3.3
+ 33600.1000n 0 33900.0000n 0 33900.1000n 3.3 34200.0000n 3.3 34200.1000n 0 34500.0000n 0 34500.1000n 3.3 34800.0000n 3.3
+ 34800.1000n 0 35100.0000n 0 35100.1000n 3.3 35400.0000n 3.3 35400.1000n 0 35700.0000n 0 35700.1000n 3.3 36000.0000n 3.3
+ 36000.1000n 0 36300.0000n 0 36300.1000n 3.3 36600.0000n 3.3 36600.1000n 0 36900.0000n 0 36900.1000n 3.3 37200.0000n 3.3
+ 37200.1000n 0 37500.0000n 0 37500.1000n 3.3 37800.0000n 3.3 37800.1000n 0 38100.0000n 0 38100.1000n 3.3 38400.0000n 3.3
+ 38400.1000n 0 38700.0000n 0 38700.1000n 3.3 39000.0000n 3.3 39000.1000n 0 39300.0000n 0 39300.1000n 3.3 39600.0000n 3.3
+ 39600.1000n 0 39900.0000n 0 39900.1000n 3.3 40200.0000n 3.3 40200.1000n 0 40500.0000n 0 40500.1000n 3.3 40800.0000n 3.3
+ 40800.1000n 0 41100.0000n 0 41100.1000n 3.3 41400.0000n 3.3 41400.1000n 0 41700.0000n 0 41700.1000n 3.3 42000.0000n 3.3
+ 42000.1000n 0 42300.0000n 0 42300.1000n 3.3 42600.0000n 3.3 42600.1000n 0 42900.0000n 0 42900.1000n 3.3 43200.0000n 3.3
+ 43200.1000n 0 43500.0000n 0 43500.1000n 3.3 43800.0000n 3.3 43800.1000n 0 44100.0000n 0 44100.1000n 3.3 44400.0000n 3.3
+ 44400.1000n 0 44700.0000n 0 44700.1000n 3.3 45000.0000n 3.3 45000.1000n 0 45300.0000n 0 45300.1000n 3.3 45600.0000n 3.3
+ 45600.1000n 0 45900.0000n 0 45900.1000n 3.3 46200.0000n 3.3 46200.1000n 0 46500.0000n 0 46500.1000n 3.3 46800.0000n 3.3
+ 46800.1000n 0 47100.0000n 0 47100.1000n 3.3 47400.0000n 3.3 47400.1000n 0 47700.0000n 0 47700.1000n 3.3 48000.0000n 3.3
+ 48000.1000n 0 48300.0000n 0 48300.1000n 3.3 48600.0000n 3.3 48600.1000n 0 48900.0000n 0 48900.1000n 3.3 49200.0000n 3.3
+ 49200.1000n 0 49500.0000n 0 49500.1000n 3.3 49800.0000n 3.3 49800.1000n 0 50100.0000n 0 50100.1000n 3.3 50400.0000n 3.3
+ 50400.1000n 0 50700.0000n 0 50700.1000n 3.3 51000.0000n 3.3 51000.1000n 0 51300.0000n 0 51300.1000n 3.3 51600.0000n 3.3
+ 51600.1000n 0 51900.0000n 0 51900.1000n 3.3 52200.0000n 3.3 52200.1000n 0 52500.0000n 0 52500.1000n 3.3 52800.0000n 3.3
+ 52800.1000n 0 53100.0000n 0 53100.1000n 3.3 53400.0000n 3.3 53400.1000n 0 53700.0000n 0 53700.1000n 3.3 54000.0000n 3.3
+ 54000.1000n 0 54300.0000n 0 54300.1000n 3.3 54600.0000n 3.3 54600.1000n 0 54900.0000n 0 54900.1000n 3.3 55200.0000n 3.3
+ 55200.1000n 0 55500.0000n 0 55500.1000n 3.3 55800.0000n 3.3 55800.1000n 0 56100.0000n 0 56100.1000n 3.3 56400.0000n 3.3
+ 56400.1000n 0 56700.0000n 0 56700.1000n 3.3 57000.0000n 3.3 57000.1000n 0 57300.0000n 0 57300.1000n 3.3 57600.0000n 3.3
+ 57600.1000n 0 57900.0000n 0 57900.1000n 3.3 58200.0000n 3.3 58200.1000n 0 58500.0000n 0 58500.1000n 3.3 58800.0000n 3.3
+ 58800.1000n 0 59100.0000n 0 59100.1000n 3.3 59400.0000n 3.3 59400.1000n 0 59700.0000n 0 59700.1000n 3.3 60000.0000n 3.3
+ 60000.1000n 0 60300.0000n 0 60300.1000n 3.3 60600.0000n 3.3 60600.1000n 0 60900.0000n 0 60900.1000n 3.3 61200.0000n 3.3
+ 61200.1000n 0 61500.0000n 0 61500.1000n 3.3 61800.0000n 3.3 61800.1000n 0 62100.0000n 0 62100.1000n 3.3 62400.0000n 3.3
+ 62400.1000n 0 62700.0000n 0 62700.1000n 3.3 63000.0000n 3.3 63000.1000n 0 63300.0000n 0 63300.1000n 3.3 63600.0000n 3.3
+ 63600.1000n 0 63900.0000n 0 63900.1000n 3.3 64200.0000n 3.3 64200.1000n 0 64500.0000n 0 64500.1000n 3.3 64800.0000n 3.3
+ 64800.1000n 0 65100.0000n 0 65100.1000n 3.3 65400.0000n 3.3 65400.1000n 0 65700.0000n 0 65700.1000n 3.3 66000.0000n 3.3
+ 66000.1000n 0 66300.0000n 0 66300.1000n 3.3 66600.0000n 3.3 66600.1000n 0 66900.0000n 0 66900.1000n 3.3 67200.0000n 3.3
+ 67200.1000n 0 67500.0000n 0 67500.1000n 3.3 67800.0000n 3.3 67800.1000n 0 68100.0000n 0 68100.1000n 3.3 68400.0000n 3.3
+ 68400.1000n 0 68700.0000n 0 68700.1000n 3.3 69000.0000n 3.3 69000.1000n 0 69300.0000n 0 69300.1000n 3.3 69600.0000n 3.3
+ 69600.1000n 0 69900.0000n 0 69900.1000n 3.3 70200.0000n 3.3 70200.1000n 0 70500.0000n 0 70500.1000n 3.3 70800.0000n 3.3
+ 70800.1000n 0 71100.0000n 0 71100.1000n 3.3 71400.0000n 3.3 71400.1000n 0 71700.0000n 0 71700.1000n 3.3 72000.0000n 3.3
+ 72000.1000n 0 72300.0000n 0 72300.1000n 3.3 72600.0000n 3.3 72600.1000n 0 72900.0000n 0 72900.1000n 3.3 73200.0000n 3.3
+ 73200.1000n 0 73500.0000n 0 73500.1000n 3.3 73800.0000n 3.3 73800.1000n 0 74100.0000n 0 74100.1000n 3.3 74400.0000n 3.3
+ 74400.1000n 0 74700.0000n 0 74700.1000n 3.3 75000.0000n 3.3 75000.1000n 0 75300.0000n 0 75300.1000n 3.3 75600.0000n 3.3
+ 75600.1000n 0 75900.0000n 0 75900.1000n 3.3 76200.0000n 3.3 76200.1000n 0 76500.0000n 0 76500.1000n 3.3 76800.0000n 3.3)

VDXB1 net6 GND PWL(0.0000n 3.3 300.0000n 3.3 300.1000n 0 600.0000n 0 600.1000n 3.3 900.0000n 3.3 900.1000n 0 1200.0000n 0
+ 1200.1000n 3.3 1500.0000n 3.3 1500.1000n 0 1800.0000n 0 1800.1000n 3.3 2100.0000n 3.3 2100.1000n 0 2400.0000n 0
+ 2400.1000n 3.3 2700.0000n 3.3 2700.1000n 0 3000.0000n 0 3000.1000n 3.3 3300.0000n 3.3 3300.1000n 0 3600.0000n 0
+ 3600.1000n 3.3 3900.0000n 3.3 3900.1000n 0 4200.0000n 0 4200.1000n 3.3 4500.0000n 3.3 4500.1000n 0 4800.0000n 0
+ 4800.1000n 3.3 5100.0000n 3.3 5100.1000n 0 5400.0000n 0 5400.1000n 3.3 5700.0000n 3.3 5700.1000n 0 6000.0000n 0
+ 6000.1000n 3.3 6300.0000n 3.3 6300.1000n 0 6600.0000n 0 6600.1000n 3.3 6900.0000n 3.3 6900.1000n 0 7200.0000n 0
+ 7200.1000n 3.3 7500.0000n 3.3 7500.1000n 0 7800.0000n 0 7800.1000n 3.3 8100.0000n 3.3 8100.1000n 0 8400.0000n 0
+ 8400.1000n 3.3 8700.0000n 3.3 8700.1000n 0 9000.0000n 0 9000.1000n 3.3 9300.0000n 3.3 9300.1000n 0 9600.0000n 0
+ 9600.1000n 3.3 9900.0000n 3.3 9900.1000n 0 10200.0000n 0 10200.1000n 3.3 10500.0000n 3.3 10500.1000n 0 10800.0000n 0
+ 10800.1000n 3.3 11100.0000n 3.3 11100.1000n 0 11400.0000n 0 11400.1000n 3.3 11700.0000n 3.3 11700.1000n 0 12000.0000n 0
+ 12000.1000n 3.3 12300.0000n 3.3 12300.1000n 0 12600.0000n 0 12600.1000n 3.3 12900.0000n 3.3 12900.1000n 0 13200.0000n 0
+ 13200.1000n 3.3 13500.0000n 3.3 13500.1000n 0 13800.0000n 0 13800.1000n 3.3 14100.0000n 3.3 14100.1000n 0 14400.0000n 0
+ 14400.1000n 3.3 14700.0000n 3.3 14700.1000n 0 15000.0000n 0 15000.1000n 3.3 15300.0000n 3.3 15300.1000n 0 15600.0000n 0
+ 15600.1000n 3.3 15900.0000n 3.3 15900.1000n 0 16200.0000n 0 16200.1000n 3.3 16500.0000n 3.3 16500.1000n 0 16800.0000n 0
+ 16800.1000n 3.3 17100.0000n 3.3 17100.1000n 0 17400.0000n 0 17400.1000n 3.3 17700.0000n 3.3 17700.1000n 0 18000.0000n 0
+ 18000.1000n 3.3 18300.0000n 3.3 18300.1000n 0 18600.0000n 0 18600.1000n 3.3 18900.0000n 3.3 18900.1000n 0 19200.0000n 0
+ 19200.1000n 3.3 19500.0000n 3.3 19500.1000n 0 19800.0000n 0 19800.1000n 3.3 20100.0000n 3.3 20100.1000n 0 20400.0000n 0
+ 20400.1000n 3.3 20700.0000n 3.3 20700.1000n 0 21000.0000n 0 21000.1000n 3.3 21300.0000n 3.3 21300.1000n 0 21600.0000n 0
+ 21600.1000n 3.3 21900.0000n 3.3 21900.1000n 0 22200.0000n 0 22200.1000n 3.3 22500.0000n 3.3 22500.1000n 0 22800.0000n 0
+ 22800.1000n 3.3 23100.0000n 3.3 23100.1000n 0 23400.0000n 0 23400.1000n 3.3 23700.0000n 3.3 23700.1000n 0 24000.0000n 0
+ 24000.1000n 3.3 24300.0000n 3.3 24300.1000n 0 24600.0000n 0 24600.1000n 3.3 24900.0000n 3.3 24900.1000n 0 25200.0000n 0
+ 25200.1000n 3.3 25500.0000n 3.3 25500.1000n 0 25800.0000n 0 25800.1000n 3.3 26100.0000n 3.3 26100.1000n 0 26400.0000n 0
+ 26400.1000n 3.3 26700.0000n 3.3 26700.1000n 0 27000.0000n 0 27000.1000n 3.3 27300.0000n 3.3 27300.1000n 0 27600.0000n 0
+ 27600.1000n 3.3 27900.0000n 3.3 27900.1000n 0 28200.0000n 0 28200.1000n 3.3 28500.0000n 3.3 28500.1000n 0 28800.0000n 0
+ 28800.1000n 3.3 29100.0000n 3.3 29100.1000n 0 29400.0000n 0 29400.1000n 3.3 29700.0000n 3.3 29700.1000n 0 30000.0000n 0
+ 30000.1000n 3.3 30300.0000n 3.3 30300.1000n 0 30600.0000n 0 30600.1000n 3.3 30900.0000n 3.3 30900.1000n 0 31200.0000n 0
+ 31200.1000n 3.3 31500.0000n 3.3 31500.1000n 0 31800.0000n 0 31800.1000n 3.3 32100.0000n 3.3 32100.1000n 0 32400.0000n 0
+ 32400.1000n 3.3 32700.0000n 3.3 32700.1000n 0 33000.0000n 0 33000.1000n 3.3 33300.0000n 3.3 33300.1000n 0 33600.0000n 0
+ 33600.1000n 3.3 33900.0000n 3.3 33900.1000n 0 34200.0000n 0 34200.1000n 3.3 34500.0000n 3.3 34500.1000n 0 34800.0000n 0
+ 34800.1000n 3.3 35100.0000n 3.3 35100.1000n 0 35400.0000n 0 35400.1000n 3.3 35700.0000n 3.3 35700.1000n 0 36000.0000n 0
+ 36000.1000n 3.3 36300.0000n 3.3 36300.1000n 0 36600.0000n 0 36600.1000n 3.3 36900.0000n 3.3 36900.1000n 0 37200.0000n 0
+ 37200.1000n 3.3 37500.0000n 3.3 37500.1000n 0 37800.0000n 0 37800.1000n 3.3 38100.0000n 3.3 38100.1000n 0 38400.0000n 0
+ 38400.1000n 3.3 38700.0000n 3.3 38700.1000n 0 39000.0000n 0 39000.1000n 3.3 39300.0000n 3.3 39300.1000n 0 39600.0000n 0
+ 39600.1000n 3.3 39900.0000n 3.3 39900.1000n 0 40200.0000n 0 40200.1000n 3.3 40500.0000n 3.3 40500.1000n 0 40800.0000n 0
+ 40800.1000n 3.3 41100.0000n 3.3 41100.1000n 0 41400.0000n 0 41400.1000n 3.3 41700.0000n 3.3 41700.1000n 0 42000.0000n 0
+ 42000.1000n 3.3 42300.0000n 3.3 42300.1000n 0 42600.0000n 0 42600.1000n 3.3 42900.0000n 3.3 42900.1000n 0 43200.0000n 0
+ 43200.1000n 3.3 43500.0000n 3.3 43500.1000n 0 43800.0000n 0 43800.1000n 3.3 44100.0000n 3.3 44100.1000n 0 44400.0000n 0
+ 44400.1000n 3.3 44700.0000n 3.3 44700.1000n 0 45000.0000n 0 45000.1000n 3.3 45300.0000n 3.3 45300.1000n 0 45600.0000n 0
+ 45600.1000n 3.3 45900.0000n 3.3 45900.1000n 0 46200.0000n 0 46200.1000n 3.3 46500.0000n 3.3 46500.1000n 0 46800.0000n 0
+ 46800.1000n 3.3 47100.0000n 3.3 47100.1000n 0 47400.0000n 0 47400.1000n 3.3 47700.0000n 3.3 47700.1000n 0 48000.0000n 0
+ 48000.1000n 3.3 48300.0000n 3.3 48300.1000n 0 48600.0000n 0 48600.1000n 3.3 48900.0000n 3.3 48900.1000n 0 49200.0000n 0
+ 49200.1000n 3.3 49500.0000n 3.3 49500.1000n 0 49800.0000n 0 49800.1000n 3.3 50100.0000n 3.3 50100.1000n 0 50400.0000n 0
+ 50400.1000n 3.3 50700.0000n 3.3 50700.1000n 0 51000.0000n 0 51000.1000n 3.3 51300.0000n 3.3 51300.1000n 0 51600.0000n 0
+ 51600.1000n 3.3 51900.0000n 3.3 51900.1000n 0 52200.0000n 0 52200.1000n 3.3 52500.0000n 3.3 52500.1000n 0 52800.0000n 0
+ 52800.1000n 3.3 53100.0000n 3.3 53100.1000n 0 53400.0000n 0 53400.1000n 3.3 53700.0000n 3.3 53700.1000n 0 54000.0000n 0
+ 54000.1000n 3.3 54300.0000n 3.3 54300.1000n 0 54600.0000n 0 54600.1000n 3.3 54900.0000n 3.3 54900.1000n 0 55200.0000n 0
+ 55200.1000n 3.3 55500.0000n 3.3 55500.1000n 0 55800.0000n 0 55800.1000n 3.3 56100.0000n 3.3 56100.1000n 0 56400.0000n 0
+ 56400.1000n 3.3 56700.0000n 3.3 56700.1000n 0 57000.0000n 0 57000.1000n 3.3 57300.0000n 3.3 57300.1000n 0 57600.0000n 0
+ 57600.1000n 3.3 57900.0000n 3.3 57900.1000n 0 58200.0000n 0 58200.1000n 3.3 58500.0000n 3.3 58500.1000n 0 58800.0000n 0
+ 58800.1000n 3.3 59100.0000n 3.3 59100.1000n 0 59400.0000n 0 59400.1000n 3.3 59700.0000n 3.3 59700.1000n 0 60000.0000n 0
+ 60000.1000n 3.3 60300.0000n 3.3 60300.1000n 0 60600.0000n 0 60600.1000n 3.3 60900.0000n 3.3 60900.1000n 0 61200.0000n 0
+ 61200.1000n 3.3 61500.0000n 3.3 61500.1000n 0 61800.0000n 0 61800.1000n 3.3 62100.0000n 3.3 62100.1000n 0 62400.0000n 0
+ 62400.1000n 3.3 62700.0000n 3.3 62700.1000n 0 63000.0000n 0 63000.1000n 3.3 63300.0000n 3.3 63300.1000n 0 63600.0000n 0
+ 63600.1000n 3.3 63900.0000n 3.3 63900.1000n 0 64200.0000n 0 64200.1000n 3.3 64500.0000n 3.3 64500.1000n 0 64800.0000n 0
+ 64800.1000n 3.3 65100.0000n 3.3 65100.1000n 0 65400.0000n 0 65400.1000n 3.3 65700.0000n 3.3 65700.1000n 0 66000.0000n 0
+ 66000.1000n 3.3 66300.0000n 3.3 66300.1000n 0 66600.0000n 0 66600.1000n 3.3 66900.0000n 3.3 66900.1000n 0 67200.0000n 0
+ 67200.1000n 3.3 67500.0000n 3.3 67500.1000n 0 67800.0000n 0 67800.1000n 3.3 68100.0000n 3.3 68100.1000n 0 68400.0000n 0
+ 68400.1000n 3.3 68700.0000n 3.3 68700.1000n 0 69000.0000n 0 69000.1000n 3.3 69300.0000n 3.3 69300.1000n 0 69600.0000n 0
+ 69600.1000n 3.3 69900.0000n 3.3 69900.1000n 0 70200.0000n 0 70200.1000n 3.3 70500.0000n 3.3 70500.1000n 0 70800.0000n 0
+ 70800.1000n 3.3 71100.0000n 3.3 71100.1000n 0 71400.0000n 0 71400.1000n 3.3 71700.0000n 3.3 71700.1000n 0 72000.0000n 0
+ 72000.1000n 3.3 72300.0000n 3.3 72300.1000n 0 72600.0000n 0 72600.1000n 3.3 72900.0000n 3.3 72900.1000n 0 73200.0000n 0
+ 73200.1000n 3.3 73500.0000n 3.3 73500.1000n 0 73800.0000n 0 73800.1000n 3.3 74100.0000n 3.3 74100.1000n 0 74400.0000n 0
+ 74400.1000n 3.3 74700.0000n 3.3 74700.1000n 0 75000.0000n 0 75000.1000n 3.3 75300.0000n 3.3 75300.1000n 0 75600.0000n 0
+ 75600.1000n 3.3 75900.0000n 3.3 75900.1000n 0 76200.0000n 0 76200.1000n 3.3 76500.0000n 3.3 76500.1000n 0 76800.0000n 0)

VDX2  net18 GND PWL(0.0000n 0 600.0000n 0 600.1000n 3.3 1200.0000n 3.3 1200.1000n 0 1800.0000n 0 1800.1000n 3.3 2400.0000n 3.3
+ 2400.1000n 0 3000.0000n 0 3000.1000n 3.3 3600.0000n 3.3 3600.1000n 0 4200.0000n 0 4200.1000n 3.3 4800.0000n 3.3
+ 4800.1000n 0 5400.0000n 0 5400.1000n 3.3 6000.0000n 3.3 6000.1000n 0 6600.0000n 0 6600.1000n 3.3 7200.0000n 3.3
+ 7200.1000n 0 7800.0000n 0 7800.1000n 3.3 8400.0000n 3.3 8400.1000n 0 9000.0000n 0 9000.1000n 3.3 9600.0000n 3.3
+ 9600.1000n 0 10200.0000n 0 10200.1000n 3.3 10800.0000n 3.3 10800.1000n 0 11400.0000n 0 11400.1000n 3.3 12000.0000n 3.3
+ 12000.1000n 0 12600.0000n 0 12600.1000n 3.3 13200.0000n 3.3 13200.1000n 0 13800.0000n 0 13800.1000n 3.3 14400.0000n 3.3
+ 14400.1000n 0 15000.0000n 0 15000.1000n 3.3 15600.0000n 3.3 15600.1000n 0 16200.0000n 0 16200.1000n 3.3 16800.0000n 3.3
+ 16800.1000n 0 17400.0000n 0 17400.1000n 3.3 18000.0000n 3.3 18000.1000n 0 18600.0000n 0 18600.1000n 3.3 19200.0000n 3.3
+ 19200.1000n 0 19800.0000n 0 19800.1000n 3.3 20400.0000n 3.3 20400.1000n 0 21000.0000n 0 21000.1000n 3.3 21600.0000n 3.3
+ 21600.1000n 0 22200.0000n 0 22200.1000n 3.3 22800.0000n 3.3 22800.1000n 0 23400.0000n 0 23400.1000n 3.3 24000.0000n 3.3
+ 24000.1000n 0 24600.0000n 0 24600.1000n 3.3 25200.0000n 3.3 25200.1000n 0 25800.0000n 0 25800.1000n 3.3 26400.0000n 3.3
+ 26400.1000n 0 27000.0000n 0 27000.1000n 3.3 27600.0000n 3.3 27600.1000n 0 28200.0000n 0 28200.1000n 3.3 28800.0000n 3.3
+ 28800.1000n 0 29400.0000n 0 29400.1000n 3.3 30000.0000n 3.3 30000.1000n 0 30600.0000n 0 30600.1000n 3.3 31200.0000n 3.3
+ 31200.1000n 0 31800.0000n 0 31800.1000n 3.3 32400.0000n 3.3 32400.1000n 0 33000.0000n 0 33000.1000n 3.3 33600.0000n 3.3
+ 33600.1000n 0 34200.0000n 0 34200.1000n 3.3 34800.0000n 3.3 34800.1000n 0 35400.0000n 0 35400.1000n 3.3 36000.0000n 3.3
+ 36000.1000n 0 36600.0000n 0 36600.1000n 3.3 37200.0000n 3.3 37200.1000n 0 37800.0000n 0 37800.1000n 3.3 38400.0000n 3.3
+ 38400.1000n 0 39000.0000n 0 39000.1000n 3.3 39600.0000n 3.3 39600.1000n 0 40200.0000n 0 40200.1000n 3.3 40800.0000n 3.3
+ 40800.1000n 0 41400.0000n 0 41400.1000n 3.3 42000.0000n 3.3 42000.1000n 0 42600.0000n 0 42600.1000n 3.3 43200.0000n 3.3
+ 43200.1000n 0 43800.0000n 0 43800.1000n 3.3 44400.0000n 3.3 44400.1000n 0 45000.0000n 0 45000.1000n 3.3 45600.0000n 3.3
+ 45600.1000n 0 46200.0000n 0 46200.1000n 3.3 46800.0000n 3.3 46800.1000n 0 47400.0000n 0 47400.1000n 3.3 48000.0000n 3.3
+ 48000.1000n 0 48600.0000n 0 48600.1000n 3.3 49200.0000n 3.3 49200.1000n 0 49800.0000n 0 49800.1000n 3.3 50400.0000n 3.3
+ 50400.1000n 0 51000.0000n 0 51000.1000n 3.3 51600.0000n 3.3 51600.1000n 0 52200.0000n 0 52200.1000n 3.3 52800.0000n 3.3
+ 52800.1000n 0 53400.0000n 0 53400.1000n 3.3 54000.0000n 3.3 54000.1000n 0 54600.0000n 0 54600.1000n 3.3 55200.0000n 3.3
+ 55200.1000n 0 55800.0000n 0 55800.1000n 3.3 56400.0000n 3.3 56400.1000n 0 57000.0000n 0 57000.1000n 3.3 57600.0000n 3.3
+ 57600.1000n 0 58200.0000n 0 58200.1000n 3.3 58800.0000n 3.3 58800.1000n 0 59400.0000n 0 59400.1000n 3.3 60000.0000n 3.3
+ 60000.1000n 0 60600.0000n 0 60600.1000n 3.3 61200.0000n 3.3 61200.1000n 0 61800.0000n 0 61800.1000n 3.3 62400.0000n 3.3
+ 62400.1000n 0 63000.0000n 0 63000.1000n 3.3 63600.0000n 3.3 63600.1000n 0 64200.0000n 0 64200.1000n 3.3 64800.0000n 3.3
+ 64800.1000n 0 65400.0000n 0 65400.1000n 3.3 66000.0000n 3.3 66000.1000n 0 66600.0000n 0 66600.1000n 3.3 67200.0000n 3.3
+ 67200.1000n 0 67800.0000n 0 67800.1000n 3.3 68400.0000n 3.3 68400.1000n 0 69000.0000n 0 69000.1000n 3.3 69600.0000n 3.3
+ 69600.1000n 0 70200.0000n 0 70200.1000n 3.3 70800.0000n 3.3 70800.1000n 0 71400.0000n 0 71400.1000n 3.3 72000.0000n 3.3
+ 72000.1000n 0 72600.0000n 0 72600.1000n 3.3 73200.0000n 3.3 73200.1000n 0 73800.0000n 0 73800.1000n 3.3 74400.0000n 3.3
+ 74400.1000n 0 75000.0000n 0 75000.1000n 3.3 75600.0000n 3.3 75600.1000n 0 76200.0000n 0 76200.1000n 3.3 76800.0000n 3.3)

VDXB2 net7 GND PWL(0.0000n 3.3 600.0000n 3.3 600.1000n 0 1200.0000n 0 1200.1000n 3.3 1800.0000n 3.3 1800.1000n 0 2400.0000n 0
+ 2400.1000n 3.3 3000.0000n 3.3 3000.1000n 0 3600.0000n 0 3600.1000n 3.3 4200.0000n 3.3 4200.1000n 0 4800.0000n 0
+ 4800.1000n 3.3 5400.0000n 3.3 5400.1000n 0 6000.0000n 0 6000.1000n 3.3 6600.0000n 3.3 6600.1000n 0 7200.0000n 0
+ 7200.1000n 3.3 7800.0000n 3.3 7800.1000n 0 8400.0000n 0 8400.1000n 3.3 9000.0000n 3.3 9000.1000n 0 9600.0000n 0
+ 9600.1000n 3.3 10200.0000n 3.3 10200.1000n 0 10800.0000n 0 10800.1000n 3.3 11400.0000n 3.3 11400.1000n 0 12000.0000n 0
+ 12000.1000n 3.3 12600.0000n 3.3 12600.1000n 0 13200.0000n 0 13200.1000n 3.3 13800.0000n 3.3 13800.1000n 0 14400.0000n 0
+ 14400.1000n 3.3 15000.0000n 3.3 15000.1000n 0 15600.0000n 0 15600.1000n 3.3 16200.0000n 3.3 16200.1000n 0 16800.0000n 0
+ 16800.1000n 3.3 17400.0000n 3.3 17400.1000n 0 18000.0000n 0 18000.1000n 3.3 18600.0000n 3.3 18600.1000n 0 19200.0000n 0
+ 19200.1000n 3.3 19800.0000n 3.3 19800.1000n 0 20400.0000n 0 20400.1000n 3.3 21000.0000n 3.3 21000.1000n 0 21600.0000n 0
+ 21600.1000n 3.3 22200.0000n 3.3 22200.1000n 0 22800.0000n 0 22800.1000n 3.3 23400.0000n 3.3 23400.1000n 0 24000.0000n 0
+ 24000.1000n 3.3 24600.0000n 3.3 24600.1000n 0 25200.0000n 0 25200.1000n 3.3 25800.0000n 3.3 25800.1000n 0 26400.0000n 0
+ 26400.1000n 3.3 27000.0000n 3.3 27000.1000n 0 27600.0000n 0 27600.1000n 3.3 28200.0000n 3.3 28200.1000n 0 28800.0000n 0
+ 28800.1000n 3.3 29400.0000n 3.3 29400.1000n 0 30000.0000n 0 30000.1000n 3.3 30600.0000n 3.3 30600.1000n 0 31200.0000n 0
+ 31200.1000n 3.3 31800.0000n 3.3 31800.1000n 0 32400.0000n 0 32400.1000n 3.3 33000.0000n 3.3 33000.1000n 0 33600.0000n 0
+ 33600.1000n 3.3 34200.0000n 3.3 34200.1000n 0 34800.0000n 0 34800.1000n 3.3 35400.0000n 3.3 35400.1000n 0 36000.0000n 0
+ 36000.1000n 3.3 36600.0000n 3.3 36600.1000n 0 37200.0000n 0 37200.1000n 3.3 37800.0000n 3.3 37800.1000n 0 38400.0000n 0
+ 38400.1000n 3.3 39000.0000n 3.3 39000.1000n 0 39600.0000n 0 39600.1000n 3.3 40200.0000n 3.3 40200.1000n 0 40800.0000n 0
+ 40800.1000n 3.3 41400.0000n 3.3 41400.1000n 0 42000.0000n 0 42000.1000n 3.3 42600.0000n 3.3 42600.1000n 0 43200.0000n 0
+ 43200.1000n 3.3 43800.0000n 3.3 43800.1000n 0 44400.0000n 0 44400.1000n 3.3 45000.0000n 3.3 45000.1000n 0 45600.0000n 0
+ 45600.1000n 3.3 46200.0000n 3.3 46200.1000n 0 46800.0000n 0 46800.1000n 3.3 47400.0000n 3.3 47400.1000n 0 48000.0000n 0
+ 48000.1000n 3.3 48600.0000n 3.3 48600.1000n 0 49200.0000n 0 49200.1000n 3.3 49800.0000n 3.3 49800.1000n 0 50400.0000n 0
+ 50400.1000n 3.3 51000.0000n 3.3 51000.1000n 0 51600.0000n 0 51600.1000n 3.3 52200.0000n 3.3 52200.1000n 0 52800.0000n 0
+ 52800.1000n 3.3 53400.0000n 3.3 53400.1000n 0 54000.0000n 0 54000.1000n 3.3 54600.0000n 3.3 54600.1000n 0 55200.0000n 0
+ 55200.1000n 3.3 55800.0000n 3.3 55800.1000n 0 56400.0000n 0 56400.1000n 3.3 57000.0000n 3.3 57000.1000n 0 57600.0000n 0
+ 57600.1000n 3.3 58200.0000n 3.3 58200.1000n 0 58800.0000n 0 58800.1000n 3.3 59400.0000n 3.3 59400.1000n 0 60000.0000n 0
+ 60000.1000n 3.3 60600.0000n 3.3 60600.1000n 0 61200.0000n 0 61200.1000n 3.3 61800.0000n 3.3 61800.1000n 0 62400.0000n 0
+ 62400.1000n 3.3 63000.0000n 3.3 63000.1000n 0 63600.0000n 0 63600.1000n 3.3 64200.0000n 3.3 64200.1000n 0 64800.0000n 0
+ 64800.1000n 3.3 65400.0000n 3.3 65400.1000n 0 66000.0000n 0 66000.1000n 3.3 66600.0000n 3.3 66600.1000n 0 67200.0000n 0
+ 67200.1000n 3.3 67800.0000n 3.3 67800.1000n 0 68400.0000n 0 68400.1000n 3.3 69000.0000n 3.3 69000.1000n 0 69600.0000n 0
+ 69600.1000n 3.3 70200.0000n 3.3 70200.1000n 0 70800.0000n 0 70800.1000n 3.3 71400.0000n 3.3 71400.1000n 0 72000.0000n 0
+ 72000.1000n 3.3 72600.0000n 3.3 72600.1000n 0 73200.0000n 0 73200.1000n 3.3 73800.0000n 3.3 73800.1000n 0 74400.0000n 0
+ 74400.1000n 3.3 75000.0000n 3.3 75000.1000n 0 75600.0000n 0 75600.1000n 3.3 76200.0000n 3.3 76200.1000n 0 76800.0000n 0)

VDX3  net19 GND PWL(0.0000n 0 1200.0000n 0 1200.1000n 3.3 2400.0000n 3.3 2400.1000n 0 3600.0000n 0 3600.1000n 3.3 4800.0000n 3.3
+ 4800.1000n 0 6000.0000n 0 6000.1000n 3.3 7200.0000n 3.3 7200.1000n 0 8400.0000n 0 8400.1000n 3.3 9600.0000n 3.3
+ 9600.1000n 0 10800.0000n 0 10800.1000n 3.3 12000.0000n 3.3 12000.1000n 0 13200.0000n 0 13200.1000n 3.3 14400.0000n 3.3
+ 14400.1000n 0 15600.0000n 0 15600.1000n 3.3 16800.0000n 3.3 16800.1000n 0 18000.0000n 0 18000.1000n 3.3 19200.0000n 3.3
+ 19200.1000n 0 20400.0000n 0 20400.1000n 3.3 21600.0000n 3.3 21600.1000n 0 22800.0000n 0 22800.1000n 3.3 24000.0000n 3.3
+ 24000.1000n 0 25200.0000n 0 25200.1000n 3.3 26400.0000n 3.3 26400.1000n 0 27600.0000n 0 27600.1000n 3.3 28800.0000n 3.3
+ 28800.1000n 0 30000.0000n 0 30000.1000n 3.3 31200.0000n 3.3 31200.1000n 0 32400.0000n 0 32400.1000n 3.3 33600.0000n 3.3
+ 33600.1000n 0 34800.0000n 0 34800.1000n 3.3 36000.0000n 3.3 36000.1000n 0 37200.0000n 0 37200.1000n 3.3 38400.0000n 3.3
+ 38400.1000n 0 39600.0000n 0 39600.1000n 3.3 40800.0000n 3.3 40800.1000n 0 42000.0000n 0 42000.1000n 3.3 43200.0000n 3.3
+ 43200.1000n 0 44400.0000n 0 44400.1000n 3.3 45600.0000n 3.3 45600.1000n 0 46800.0000n 0 46800.1000n 3.3 48000.0000n 3.3
+ 48000.1000n 0 49200.0000n 0 49200.1000n 3.3 50400.0000n 3.3 50400.1000n 0 51600.0000n 0 51600.1000n 3.3 52800.0000n 3.3
+ 52800.1000n 0 54000.0000n 0 54000.1000n 3.3 55200.0000n 3.3 55200.1000n 0 56400.0000n 0 56400.1000n 3.3 57600.0000n 3.3
+ 57600.1000n 0 58800.0000n 0 58800.1000n 3.3 60000.0000n 3.3 60000.1000n 0 61200.0000n 0 61200.1000n 3.3 62400.0000n 3.3
+ 62400.1000n 0 63600.0000n 0 63600.1000n 3.3 64800.0000n 3.3 64800.1000n 0 66000.0000n 0 66000.1000n 3.3 67200.0000n 3.3
+ 67200.1000n 0 68400.0000n 0 68400.1000n 3.3 69600.0000n 3.3 69600.1000n 0 70800.0000n 0 70800.1000n 3.3 72000.0000n 3.3
+ 72000.1000n 0 73200.0000n 0 73200.1000n 3.3 74400.0000n 3.3 74400.1000n 0 75600.0000n 0 75600.1000n 3.3 76800.0000n 3.3)

VDXB3 net8 GND PWL(0.0000n 3.3 1200.0000n 3.3 1200.1000n 0 2400.0000n 0 2400.1000n 3.3 3600.0000n 3.3 3600.1000n 0 4800.0000n 0
+ 4800.1000n 3.3 6000.0000n 3.3 6000.1000n 0 7200.0000n 0 7200.1000n 3.3 8400.0000n 3.3 8400.1000n 0 9600.0000n 0
+ 9600.1000n 3.3 10800.0000n 3.3 10800.1000n 0 12000.0000n 0 12000.1000n 3.3 13200.0000n 3.3 13200.1000n 0 14400.0000n 0
+ 14400.1000n 3.3 15600.0000n 3.3 15600.1000n 0 16800.0000n 0 16800.1000n 3.3 18000.0000n 3.3 18000.1000n 0 19200.0000n 0
+ 19200.1000n 3.3 20400.0000n 3.3 20400.1000n 0 21600.0000n 0 21600.1000n 3.3 22800.0000n 3.3 22800.1000n 0 24000.0000n 0
+ 24000.1000n 3.3 25200.0000n 3.3 25200.1000n 0 26400.0000n 0 26400.1000n 3.3 27600.0000n 3.3 27600.1000n 0 28800.0000n 0
+ 28800.1000n 3.3 30000.0000n 3.3 30000.1000n 0 31200.0000n 0 31200.1000n 3.3 32400.0000n 3.3 32400.1000n 0 33600.0000n 0
+ 33600.1000n 3.3 34800.0000n 3.3 34800.1000n 0 36000.0000n 0 36000.1000n 3.3 37200.0000n 3.3 37200.1000n 0 38400.0000n 0
+ 38400.1000n 3.3 39600.0000n 3.3 39600.1000n 0 40800.0000n 0 40800.1000n 3.3 42000.0000n 3.3 42000.1000n 0 43200.0000n 0
+ 43200.1000n 3.3 44400.0000n 3.3 44400.1000n 0 45600.0000n 0 45600.1000n 3.3 46800.0000n 3.3 46800.1000n 0 48000.0000n 0
+ 48000.1000n 3.3 49200.0000n 3.3 49200.1000n 0 50400.0000n 0 50400.1000n 3.3 51600.0000n 3.3 51600.1000n 0 52800.0000n 0
+ 52800.1000n 3.3 54000.0000n 3.3 54000.1000n 0 55200.0000n 0 55200.1000n 3.3 56400.0000n 3.3 56400.1000n 0 57600.0000n 0
+ 57600.1000n 3.3 58800.0000n 3.3 58800.1000n 0 60000.0000n 0 60000.1000n 3.3 61200.0000n 3.3 61200.1000n 0 62400.0000n 0
+ 62400.1000n 3.3 63600.0000n 3.3 63600.1000n 0 64800.0000n 0 64800.1000n 3.3 66000.0000n 3.3 66000.1000n 0 67200.0000n 0
+ 67200.1000n 3.3 68400.0000n 3.3 68400.1000n 0 69600.0000n 0 69600.1000n 3.3 70800.0000n 3.3 70800.1000n 0 72000.0000n 0
+ 72000.1000n 3.3 73200.0000n 3.3 73200.1000n 0 74400.0000n 0 74400.1000n 3.3 75600.0000n 3.3 75600.1000n 0 76800.0000n 0)

VDX4  net21 GND PWL(0.0000n 0 2400.0000n 0 2400.1000n 3.3 4800.0000n 3.3 4800.1000n 0 7200.0000n 0 7200.1000n 3.3 9600.0000n 3.3
+ 9600.1000n 0 12000.0000n 0 12000.1000n 3.3 14400.0000n 3.3 14400.1000n 0 16800.0000n 0 16800.1000n 3.3 19200.0000n 3.3
+ 19200.1000n 0 21600.0000n 0 21600.1000n 3.3 24000.0000n 3.3 24000.1000n 0 26400.0000n 0 26400.1000n 3.3 28800.0000n 3.3
+ 28800.1000n 0 31200.0000n 0 31200.1000n 3.3 33600.0000n 3.3 33600.1000n 0 36000.0000n 0 36000.1000n 3.3 38400.0000n 3.3
+ 38400.1000n 0 40800.0000n 0 40800.1000n 3.3 43200.0000n 3.3 43200.1000n 0 45600.0000n 0 45600.1000n 3.3 48000.0000n 3.3
+ 48000.1000n 0 50400.0000n 0 50400.1000n 3.3 52800.0000n 3.3 52800.1000n 0 55200.0000n 0 55200.1000n 3.3 57600.0000n 3.3
+ 57600.1000n 0 60000.0000n 0 60000.1000n 3.3 62400.0000n 3.3 62400.1000n 0 64800.0000n 0 64800.1000n 3.3 67200.0000n 3.3
+ 67200.1000n 0 69600.0000n 0 69600.1000n 3.3 72000.0000n 3.3 72000.1000n 0 74400.0000n 0 74400.1000n 3.3 76800.0000n 3.3)

VDXB4 net9 GND PWL(0.0000n 3.3 2400.0000n 3.3 2400.1000n 0 4800.0000n 0 4800.1000n 3.3 7200.0000n 3.3 7200.1000n 0 9600.0000n 0
+ 9600.1000n 3.3 12000.0000n 3.3 12000.1000n 0 14400.0000n 0 14400.1000n 3.3 16800.0000n 3.3 16800.1000n 0 19200.0000n 0
+ 19200.1000n 3.3 21600.0000n 3.3 21600.1000n 0 24000.0000n 0 24000.1000n 3.3 26400.0000n 3.3 26400.1000n 0 28800.0000n 0
+ 28800.1000n 3.3 31200.0000n 3.3 31200.1000n 0 33600.0000n 0 33600.1000n 3.3 36000.0000n 3.3 36000.1000n 0 38400.0000n 0
+ 38400.1000n 3.3 40800.0000n 3.3 40800.1000n 0 43200.0000n 0 43200.1000n 3.3 45600.0000n 3.3 45600.1000n 0 48000.0000n 0
+ 48000.1000n 3.3 50400.0000n 3.3 50400.1000n 0 52800.0000n 0 52800.1000n 3.3 55200.0000n 3.3 55200.1000n 0 57600.0000n 0
+ 57600.1000n 3.3 60000.0000n 3.3 60000.1000n 0 62400.0000n 0 62400.1000n 3.3 64800.0000n 3.3 64800.1000n 0 67200.0000n 0
+ 67200.1000n 3.3 69600.0000n 3.3 69600.1000n 0 72000.0000n 0 72000.1000n 3.3 74400.0000n 3.3 74400.1000n 0 76800.0000n 0)

VDX6  net23 GND PWL(0.0000n 0 4800.0000n 0 4800.1000n 3.3 9600.0000n 3.3 9600.1000n 0 14400.0000n 0 14400.1000n 3.3 19200.0000n 3.3
+ 19200.1000n 0 24000.0000n 0 24000.1000n 3.3 28800.0000n 3.3 28800.1000n 0 33600.0000n 0 33600.1000n 3.3 38400.0000n 3.3
+ 38400.1000n 0 43200.0000n 0 43200.1000n 3.3 48000.0000n 3.3 48000.1000n 0 52800.0000n 0 52800.1000n 3.3 57600.0000n 3.3
+ 57600.1000n 0 62400.0000n 0 62400.1000n 3.3 67200.0000n 3.3 67200.1000n 0 72000.0000n 0 72000.1000n 3.3 76800.0000n 3.3)

VDXB6 net11 GND PWL(0.0000n 3.3 4800.0000n 3.3 4800.1000n 0 9600.0000n 0 9600.1000n 3.3 14400.0000n 3.3 14400.1000n 0 19200.0000n 0
+ 19200.1000n 3.3 24000.0000n 3.3 24000.1000n 0 28800.0000n 0 28800.1000n 3.3 33600.0000n 3.3 33600.1000n 0 38400.0000n 0
+ 38400.1000n 3.3 43200.0000n 3.3 43200.1000n 0 48000.0000n 0 48000.1000n 3.3 52800.0000n 3.3 52800.1000n 0 57600.0000n 0
+ 57600.1000n 3.3 62400.0000n 3.3 62400.1000n 0 67200.0000n 0 67200.1000n 3.3 72000.0000n 3.3 72000.1000n 0 76800.0000n 0)

VDX7  net24 GND PWL(0.0000n 0 9600.0000n 0 9600.1000n 3.3 19200.0000n 3.3 19200.1000n 0 28800.0000n 0 28800.1000n 3.3 38400.0000n 3.3
+ 38400.1000n 0 48000.0000n 0 48000.1000n 3.3 57600.0000n 3.3 57600.1000n 0 67200.0000n 0 67200.1000n 3.3 76800.0000n 3.3)

VDXB7 net12 GND PWL(0.0000n 3.3 9600.0000n 3.3 9600.1000n 0 19200.0000n 0 19200.1000n 3.3 28800.0000n 3.3 28800.1000n 0 38400.0000n 0
+ 38400.1000n 3.3 48000.0000n 3.3 48000.1000n 0 57600.0000n 0 57600.1000n 3.3 67200.0000n 3.3 67200.1000n 0 76800.0000n 0)

VDX8  net25 GND PWL(0.0000n 0 19200.0000n 0 19200.1000n 3.3 38400.0000n 3.3 38400.1000n 0 57600.0000n 0 57600.1000n 3.3 76800.0000n 3.3)

VDXB8 net13 GND PWL(0.0000n 3.3 19200.0000n 3.3 19200.1000n 0 38400.0000n 0 38400.1000n 3.3 57600.0000n 3.3 57600.1000n 0 76800.0000n 0)

VDX9  net26 GND PWL(0.0000n 0 38400.0000n 0 38400.1000n 3.3 76800.0000n 3.3)

VDXB9 net14 GND PWL(0.0000n 3.3 38400.0000n 3.3 38400.1000n 0 76800.0000n 0)

**** begin simulation control ****

.tran 2n 76.8u

.control
run
wrdata dac_transfer.txt net17
plot net17
.endc

* ---- Test 2: INL/DNL (now a REAL code-ordered sweep, k=0..255) ----
* Each code k held for 300ns starting at t=k*300ns. Sample near the end of
* each plateau (e.g. t=k*300n + 270n) to let switching settle before reading.
* LSB = VREF/256 (only Dx<1:4>=LSB nibble, Dx<6:9>=MSB nibble are real code
* bits; Dx<0>/Dx<5> are the fixed dummy caps Cg1/Cg2).
* Use compute_inl_dnl_full.py on dac_transfer.txt to get the full INL/DNL
* curve and max/min values -- not done inline here since 256 .meas
* statements would be unwieldy; the post-processing script is cleaner.

* ---- Test 3: worst-case major-carry transition (code 127 -> 128) ----
* This is the largest possible single-code step: MSB nibble goes 0111->1000
* while LSB nibble goes 1111->0000, so every real bit switches at once.
* Code 127 starts at t=127*300n=38100n, code 128 starts at t=38400n.
.meas tran vx_before_carry FIND V(net17) AT=38399n
.meas tran vx_after_carry  FIND V(net17) AT=38400.2n
.meas tran vx_settle_early FIND V(net17) AT=38410n
.meas tran vx_settle_late  FIND V(net17) AT=38699n
.meas tran carry_step_size    PARAM='vx_after_carry - vx_before_carry'
.meas tran carry_settle_delta PARAM='vx_settle_late - vx_settle_early'

**** end simulation control ****

* ============================================================
* CDAC cell: split MSB/LSB array with bridge cap, per-bit switches
* ============================================================
.subckt caps Dx_b<0> Dx_b<1> Dx_b<2> Dx_b<3> Vin Dx_b<4> GND Dx_b<5> Dx_b<6> Dx_b<7> VREF Dx_b<8> phi_s Dx_b<9> Dx<0> VDD Dx<1> Vx
+ Dx<2> Dx<3> Vx_lsb Dx<4> Dx<5> Dx<6> Dx<7> Dx<8> Dx<9>
XC1 net2 Vx_lsb cap_mim_2f0fF c_width=4e-6 c_length=4e-6 m=1
XC2 net1 Vx_lsb cap_mim_2f0fF c_width=4e-6 c_length=4e-6 m=1
XC3 net3 Vx_lsb cap_mim_2f0fF c_width=4e-6 c_length=4e-6 m=2
XC4 net4 Vx_lsb cap_mim_2f0fF c_width=4e-6 c_length=4e-6 m=4
XC5 net5 Vx_lsb cap_mim_2f0fF c_width=4e-6 c_length=4e-6 m=8
XC6 net6 Vx cap_mim_2f0fF c_width=4e-6 c_length=4e-6 m=1
XC7 net7 Vx cap_mim_2f0fF c_width=4e-6 c_length=4e-6 m=1
XC8 net8 Vx cap_mim_2f0fF c_width=4e-6 c_length=4e-6 m=2
XC9 net9 Vx cap_mim_2f0fF c_width=4e-6 c_length=4e-6 m=4
XC10 net10 Vx cap_mim_2f0fF c_width=4e-6 c_length=4e-6 m=8
XC11 Vx_lsb Vx cap_mim_2f0fF c_width=4.13e-6 c_length=4.13e-6 m=1
x1 VDD Dx<0> Dx_b<0> phi_s VREF Vin net2 GND transistors
x2 VDD Dx<1> Dx_b<1> phi_s VREF Vin net1 GND transistors
x3 VDD Dx<4> Dx_b<4> phi_s VREF Vin net5 GND transistors
x4 VDD Dx<2> Dx_b<2> phi_s VREF Vin net3 GND transistors
x5 VDD Dx<3> Dx_b<3> phi_s VREF Vin net4 GND transistors
x6 VDD Dx<5> Dx_b<5> phi_s VREF Vin net6 GND transistors
x8 VDD Dx<7> Dx_b<7> phi_s VREF Vin net8 GND transistors
x9 VDD Dx<6> Dx_b<6> phi_s VREF Vin net7 GND transistors
x10 VDD Dx<8> Dx_b<8> phi_s VREF Vin net9 GND transistors
x11 VDD Dx<9> Dx_b<9> phi_s VREF Vin net10 GND transistors
.ends

* ============================================================
* Per-bit switch cell: complementary VREF/GND transmission gates + sampling switch
* ============================================================
.subckt transistors VDD Dx Dx_b phi_s VREF Vin sw_node GND
XM3 sw_node Dx VREF GND nfet_03v3 L=0.28u W=0.22u nf=1 ad='int((nf+1)/2) * W/nf * 0.18u' as='int((nf+2)/2) * W/nf * 0.18u' pd='2*int((nf+1)/2) * (W/nf + 0.18u)'
+ ps='2*int((nf+2)/2) * (W/nf + 0.18u)' nrd='0.18u / W' nrs='0.18u / W' sa=0 sb=0 sd=0 m=1
XM4 sw_node Dx_b VREF VDD pfet_03v3 L=0.28u W=0.22u nf=1 ad='int((nf+1)/2) * W/nf * 0.18u' as='int((nf+2)/2) * W/nf * 0.18u' pd='2*int((nf+1)/2) * (W/nf + 0.18u)'
+ ps='2*int((nf+2)/2) * (W/nf + 0.18u)' nrd='0.18u / W' nrs='0.18u / W' sa=0 sb=0 sd=0 m=1
XM6 GND Dx_b sw_node GND nfet_03v3 L=0.28u W=0.22u nf=1 ad='int((nf+1)/2) * W/nf * 0.18u' as='int((nf+2)/2) * W/nf * 0.18u' pd='2*int((nf+1)/2) * (W/nf + 0.18u)'
+ ps='2*int((nf+2)/2) * (W/nf + 0.18u)' nrd='0.18u / W' nrs='0.18u / W' sa=0 sb=0 sd=0 m=1
XM7 GND Dx sw_node VDD pfet_03v3 L=0.28u W=0.22u nf=1 ad='int((nf+1)/2) * W/nf * 0.18u' as='int((nf+2)/2) * W/nf * 0.18u' pd='2*int((nf+1)/2) * (W/nf + 0.18u)'
+ ps='2*int((nf+2)/2) * (W/nf + 0.18u)' nrd='0.18u / W' nrs='0.18u / W' sa=0 sb=0 sd=0 m=1
XM1 Vin phi_s sw_node GND nfet_03v3 L=0.28u W=0.22u nf=1 ad='int((nf+1)/2) * W/nf * 0.18u' as='int((nf+2)/2) * W/nf * 0.18u' pd='2*int((nf+1)/2) * (W/nf + 0.18u)'
+ ps='2*int((nf+2)/2) * (W/nf + 0.18u)' nrd='0.18u / W' nrs='0.18u / W' sa=0 sb=0 sd=0 m=1
.ends

.end
