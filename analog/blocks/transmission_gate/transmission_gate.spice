** sch_path: /foss/designs/chipathon-2026-ti-adc/analog/blocks/transmission_gate/transmission_gate.sch
.subckt transmission_gate vdd vout vclk_n vclk vin vss
*.PININFO vclk:I vin:I vdd:B vss:B vout:O vclk_n:I
M1 vout vclk vin vss nfet_03v3 L=0.28u W=20u nf=20
M2 vout vclk_n vin vdd pfet_03v3 L=0.28u W=40u nf=40
.ends
